reg msk_hash_lo {
    name = "Pluto MSK FPGA Hash ID - Lower 32-bits";
    regwidth = 32;
    accesswidth = 32;
    field { sw = r; hw = na; } hash_id_lo[31:0] = 0xAAAA5555;
        hash_id_lo->desc = "Lower 32-bits of Pluto MSK FPGA Hash ID";
        hash_id_lo->name = "Hash ID Lower 32-bits";
};

reg msk_hash_hi {
    name = "Pluto MSK FPGA Hash ID - Upper 32-bits";
    regwidth = 32;
    accesswidth = 32;
    field { sw = r; hw = na; } hash_id_hi[31:0] = 0x5555AAAA;
        hash_id_hi->desc = "Upper 32-bits of Pluto MSK FPGA Hash ID";
        hash_id_hi->name = "Hash ID Upper 32-bits";
};

reg msk_init {
    name = "MSK Modem Control 0";
    regwidth = 32;
    desc = "Synchronous initialization of MSK Modem functions, does not affect configuration registers.";
    field { sw = rw; hw=r; } init = 1;
        init->desc = "0 -> Normal modem operation 
                      1 -> Initialize modem";
        init->name = "Init Enable";
};

reg msk_ctrl {
    name = "MSK Modem Control 1";
    regwidth = 32;
    desc = "MSK Modem Configuration and Control";
    field { sw = rw; hw = r; } ptt = 0;
        ptt->desc = "0 -> PTT Disabled
                     1 -> PTT Enabled";
        ptt->name = "Push-to-Talk Enable";
    field { sw = rw; hw = r; } loopback_ena = 0;
        loopback_ena->desc = "0 -> Modem loopback disabled
                              1 -> Modem loopback enabled";
        loopback_ena->name = "Modem Loopback Enable";
    field { sw = rw; hw = r; } rx_invert = 0;
        rx_invert->desc = "0 -> Rx data normal
                           1 -> Rx data inverted";
        rx_invert->name = "Rx Data Invert Enable";
    field { sw = rw; hw = r; singlepulse = true; } clear_counts = 0;
        clear_counts->desc = "Clear Tx Bit Counter and Tx Enable Counter";
        clear_counts->name = "Clear Status Counters";
};

reg msk_stat_0 {
    name = "MSK Modem Status 0";
    desc = "Modem status bits";
    regwidth = 32;
    field { sw = r; hw = w; } demod_sync_lock=0;
        demod_sync_lock->desc = "Demodulator Sync Status - not currently implemented";
        demod_sync_lock->name = "Demodulator Sync Status";
    field { sw = r; hw = w; } tx_enable=0;
        tx_enable->name = "AD9363 DAC Interface Tx Enable Input Active";
        tx_enable->desc = "1 -> Data to DAC Enabled
                           0 -> Data to DAC Disabled";
    field { sw = r; hw = w; } rx_enable=0;
        rx_enable->name = "AD9363 ADC Interface Rx Enable Input Active";
        rx_enable->desc = "1 -> Data from ADC Enabled
                           0 -> Data from ADC Disabled";
    field { sw = r; hw = w; } tx_axis_valid=0;
        tx_axis_valid->name = "Tx S_AXIS_VALID";
        tx_axis_valid->desc = "1 -> S_AXIS_VALID Enabled
                           0 -> S_AXIS_VALID Disabled";
};

reg msk_stat_1 {
    name = "MSK Modem Status 1";
    desc = "Modem status data";
    regwidth = 32;
    field { sw = r; hw = w; } tx_bit_counter[31:0] = 0;
        tx_bit_counter->desc = "Count of data requests made by modem";
        tx_bit_counter->name = "Tx Bit Count";
};

reg msk_stat_2 {
    name = "MSK Modem Status 2";
    desc = "Modem status data";
    regwidth = 32;
    field { sw = r; hw = w; } tx_ena_counter[31:0] = 0;
        tx_ena_counter->desc = "Number of clocks on which Tx Enable is active";
        tx_ena_counter->name = "Tx Enable Count";
};

reg config_nco_fw {
    regwidth = 32;
    field { sw = rw; hw = r; } config_data[31:0] = 0;
        config_data->name = "Frequency Control Word";
        config_data->desc = "Sets the center frequency of the NCO as FW = Fn * 2^32/Fs, where Fn is the desired NCO frequency, and Fs is the NCO sample rate";
};

reg rx_sample_discard {
    name = "Rx Sample Discard";
    desc = "Configure samples discard operation for demodulator";
    regwidth = 32;
    field { sw = rw; hw = r;  } rx_sample_discard[7:0] = 0;
        rx_sample_discard->desc = "Number of Rx samples to discard";
        rx_sample_discard->name = "Rx Sample Discard Value";
    field { sw = rw; hw = r; } rx_nco_discard[15:8] = 0;
        rx_nco_discard->desc = "Number of NCO samples to discard";
        rx_nco_discard->name = "Rx NCO Sample Discard Value";
};

reg lpf_config_0 {
    name = "PI Controller Configuration and Low-pass Filter Configuration";
    desc = "Configure PI controller and low-pass filter";
    regwidth = 32;
    field { sw = rw; hw = r; } lpf_freeze = 0;
        lpf_freeze->name = "Freeze the accumulator's current value";
        lpf_freeze->desc = "0 -> Normal operation
                            1 -> Freeze current value";
    field { sw = rw; hw = r; } lpf_zero = 0;
        lpf_zero->name = "Hold the PI Accumulator at zero";
        lpf_zero->desc = "0 -> Normal operation
                          1 -> Zero and hold accumulator";
    field { sw = w; hw = r; } prbs_reserved[15:2] = 0;
    field { sw = rw; hw = r; } lpf_alpha[31:16] = 0;
        lpf_alpha->name = "Lowpass IIR filter alpha";
        lpf_alpha->desc = "Value controls the filter rolloff";
};

reg lpf_config_1 {
    name = "PI Controller Configuration and Low-pass Filter Configuration";
    desc = "Configure PI controller and low-pass filter";
    regwidth = 32;
    field { sw = rw; hw = r; } i_gain[15:0] = 0;
        i_gain->name = "Sets the integral gain of the PI controller integrator";
        i_gain->desc = "Integral gain value";
    field { sw = rw; hw = r; } p_gain[31:16] = 0;
        p_gain->name = "Sets the proportional gain of the PI controller integrator";
        p_gain->desc = "Proportional gain value";
};

reg data_width {
    regwidth = 32;
    field { sw = rw; hw = r; } data_width[7:0] = 8;
        data_width->name = "Modem input/output data width";
        data_width->desc = "Set the data width of the modem input/output";
};

reg prbs_ctrl {
    name = "PRBS Control 0";
    desc = "Configures operation of the PRBS Generator and Monitor";
    regwidth = 32;
    field { sw = rw; hw = r; } prbs_sel = 0;
        prbs_sel->name = "PRBS Data Select";
        prbs_sel->desc = "0 -> Select Normal Tx Data
                          1 -> Select PRBS Tx Data";
    field { sw = w; hw = r; singlepulse = true; } prbs_error_insert = 0;
        prbs_error_insert->name = "PRBS Error Insert";
        prbs_error_insert->desc = "0 -> 1 :  Insert bit error in Tx data (both Normal and PRBS)
                                   1 -> 0 : Insert bit error in Tx data (both Normal and PRBS)";
    field { sw = w; hw = r; singlepulse = true; } prbs_clear = 0;
        prbs_clear->name = "PRBS Clear Counters";
        prbs_clear->desc = "0 -> 1 : Clear PRBS Counters
                            1 -> 0 : Clear PRBS Counters";
    field { sw = w; hw = r; singlepulse = true; } prbs_manual_sync = 0;    
        prbs_manual_sync->name = "PRBS Manual Sync";
        prbs_manual_sync->desc = "0 -> 1 : Synchronize PRBS monitor
                           1 -> 0 : Synchronize PRBS monitor";
    field { sw = w; hw = r; } prbs_reserved[15:4] = 0;
    field { sw = w; hw = r; } prbs_sync_threshold[31:16] = 0;
        prbs_sync_threshold->name = "PRBS Auto Sync Threshold";
        prbs_sync_threshold->desc = "0 : Auto Sync Disabled
                           N > 0 : Auto sync after N errors";
};

reg config_prbs_seed {
    name = "PRBS Control 1";
    desc = "PRBS Initial State";
    regwidth = 32;
    field { sw = rw; hw = r; } config_data[31:0] = 0;
        config_data->name = "PRBS Seed";
        config_data->desc = "Sets the starting value of the PRBS generator";
};

reg config_prbs_poly {
    name = "PRBS Control 2";
    desc = "PRBS Polynomial";
    regwidth = 32;
    field { sw = rw; hw = r; } config_data[31:0] = 0;
        config_data->name = "PRBS Polynomial";
        config_data->desc = "Bit positions set to '1' indicate polynomial feedback positions";
};

reg config_prbs_errmask {
    name = "PRBS Control 3";
    desc = "PRBS Error Mask";
    regwidth = 32;
    field { sw = rw; hw = r; } config_data[31:0] = 0;
        config_data->name = "PRBS Error Mask";
        config_data->desc = "Bit positions set to '1' indicate bits that are inverted when a bit error is inserted";
};

reg stat_32_bits {
    name = "PRBS Status 0";
    desc = "PRBS Bits Received";
    regwidth = 32;
    field { sw = r; hw = w; } status_data[31:0] = 0;
        status_data->name = "PRBS Bits Received";
        status_data->desc = "Number of bits received by the PRBS monitor since last
                             BER can be calculated as the ratio of received bits to errored-bits";
};

reg stat_32_errs {
    name = "PRBS Status 1";
    desc = "PRBS Bit Errors";
    regwidth = 32;
    field { sw = r; hw = w; } status_data[31:0] = 0;
        status_data->name = "PRBS Bit Errors";
        status_data->desc = "Number of errored-bits received by the PRBS monitor since last sync
                             BER can be calculated as the ratio of received bits to errored-bits";
};

reg stat_32_lpf_acc {
    regwidth = 32;
    field { sw = r; hw = w; } status_data[31:0] = 0;
        status_data->name = "PI Controller Accumulator Value";
        status_data->desc = "PI Controller Accumulator Value";
};

reg msk_stat_3 {
    name = "MSK Modem Status 3";
    desc = "Modem status data";
    regwidth = 32;
    field { sw = r; hw = w; } xfer_count[31:0] = 0;
        xfer_count->desc = "Number completed S_AXIS transfers";
        xfer_count->name = "S_AXIS Transfers";
};

addrmap msk_top_regs {
    name="Pluto MSK Registers";
    desc="MSK Modem Configuration and Status Registers";
    lsb0;
    default accesswidth=32;
    addressing=compact;

//    desyrdl_interface = "AXI4L";
//    desyrdl_access_channel = 0;

    msk_hash_lo Hash_ID_Low;
    msk_hash_hi Hash_ID_High;
    msk_init MSK_Init;
    msk_ctrl MSK_Control;
    msk_stat_0 MSK_Status;
    msk_stat_1 Tx_Bit_Count;
    msk_stat_2 Tx_Enable_Count;
    config_nco_fw Fb_FreqWord;
        Fb_FreqWord->desc = "Set Modem Data Rate";
        Fb_FreqWord->name = "Bitrate NCO Frequency Control Word";
    config_nco_fw TX_F1_FreqWord;
        TX_F1_FreqWord->desc = "Set Modulator F1 Frequency";
        TX_F1_FreqWord->name = "Tx F1 NCO Frequency Control Word";
    config_nco_fw TX_F2_FreqWord;
        TX_F2_FreqWord->desc = "Set Modulator F2 Frequency";
        TX_F2_FreqWord->name = "Tx F2 NCO Frequency Control Word";
    config_nco_fw RX_F1_FreqWord;
        RX_F1_FreqWord->desc = "Set Demodulator F1 Frequency";
        RX_F1_FreqWord->name = "Rx F1 NCO Frequency Control Word";
    config_nco_fw RX_F2_FreqWord;
        RX_F2_FreqWord->desc = "Set Demodulator F2 Frequency";
        RX_F2_FreqWord->name = "Rx F2 NCO Frequency Control Word";
    lpf_config_0 LPF_Config_0;
    lpf_config_1 LPF_Config_1;
    data_width Tx_Data_Width;
        Tx_Data_Width->desc = "Set the parallel data width of the parallel-to-serial converter";
        Tx_Data_Width->name = "Modem Tx Input Data Width";
    data_width Rx_Data_Width;
        Rx_Data_Width->desc = "Set the parallel data width of the serial-to-parallel converter";
        Rx_Data_Width->name = "Modem Rx Output Data Width";
    prbs_ctrl PRBS_Control;
    config_prbs_seed PRBS_Initial_State;
    config_prbs_poly PRBS_Polynomial;
    config_prbs_errmask PRBS_Error_Mask;
    stat_32_bits PRBS_Bit_Count;
    stat_32_errs PRBS_Error_Count;
    stat_32_lpf_acc LPF_Accum_F1;
        LPF_Accum_F1->name = "F1 PI Controller Accumulator";
        LPF_Accum_F1->desc = "Value of the F1 PI Controller Accumulator";
    stat_32_lpf_acc LPF_Accum_F2;
        LPF_Accum_F2->name = "F2 PI Controller Accumulator";
        LPF_Accum_F2->desc = "Value of the F2 PI Controller Accumulator";
    msk_stat_3 axis_xfer_count;
    rx_sample_discard Rx_Sample_Discard;

};

addrmap Pluto_MSK_Modem {
    msk_top_regs pluto_msk_regs @0x43C00000;
};
