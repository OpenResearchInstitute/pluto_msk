reg msk_hash_lo {
    regwidth = 32;
    accesswidth = 32;
    field { sw = r; hw = na; } hash_id_lo[31:0] = 0xAAAA5555;
};

reg msk_hash_hi {
    regwidth = 32;
    accesswidth = 32;
    field { sw = r; hw = na; } hash_id_hi[31:0] = 0x5555AAAA;
};

reg msk_init {
    regwidth = 32;
    field { sw = rw; hw=r; } txrxinit = 1;
    field { sw = rw; hw=r; } txinit = 1;
    field { sw = rw; hw=r; } rxinit = 1;
};

reg msk_ctrl {
    regwidth = 32;
    field { sw = rw; hw = r; } ptt = 0;
    field { sw = rw; hw = r; } loopback_ena = 0;
    field { sw = rw; hw = r; } rx_invert = 0;
    field { sw = rw; hw = r; singlepulse = true; } clear_counts = 0;
    field { sw = rw; hw = r; } diff_encoder_loopback = 0;
};

reg msk_stat_0 {
    regwidth = 32;
    field { sw = r; hw = w; } demod_sync_lock=0;
    field { sw = r; hw = w; } tx_enable=0;
    field { sw = r; hw = w; } rx_enable=0;
    field { sw = r; hw = w; } tx_axis_valid=0;
};

reg msk_stat_1 {
    regwidth = 32;
    field { sw = r; hw = w; } tx_bit_counter[31:0] = 0;
};

reg msk_stat_2 {
    regwidth = 32;
    field { sw = r; hw = w; } tx_ena_counter[31:0] = 0;
};

reg config_nco_fw {
    regwidth = 32;
    field { sw = rw; hw = r; } config_data[31:0] = 0;
};

reg rx_sample_discard {
    regwidth = 32;
    field { sw = rw; hw = r;  } rx_sample_discard[7:0] = 0;
    field { sw = rw; hw = r; } rx_nco_discard[15:8] = 0;
};

reg lpf_config_0 {
    regwidth = 32;
    field { sw = rw; hw = r; } lpf_freeze = 0;
    field { sw = rw; hw = r; } lpf_zero = 0;
    field { sw = w; hw = r; } prbs_reserved[7:2] = 0;
    field { sw = rw; hw = r; } lpf_alpha[31:8] = 0;
};

reg lpf_config_1 {
    regwidth = 32;
    field { sw = rw; hw = r; } i_gain[23:0] = 0;
    field { sw = rw; hw = r; } i_shift[31:24] = 0;
};

reg lpf_config_2 {
    regwidth = 32;
    field { sw = rw; hw = r; } p_gain[23:0] = 0;
    field { sw = rw; hw = r; } p_shift[31:24] = 0;
};

reg data_width {
    regwidth = 32;
    field { sw = rw; hw = r; } data_width[7:0] = 8;
};

reg prbs_ctrl {
    regwidth = 32;
    field { sw = rw; hw = r; } prbs_sel = 0;
    field { sw = w; hw = r; singlepulse = true; } prbs_error_insert = 0;
    field { sw = w; hw = r; singlepulse = true; } prbs_clear = 0;
    field { sw = w; hw = r; singlepulse = true; } prbs_manual_sync = 0;    
    field { sw = w; hw = r; } prbs_reserved[15:4] = 0;
    field { sw = w; hw = r; } prbs_sync_threshold[31:16] = 0;
};

reg config_prbs_seed {
    regwidth = 32;
    field { sw = rw; hw = r; } config_data[31:0] = 0;
};

reg config_prbs_poly {
    regwidth = 32;
    field { sw = rw; hw = r; } config_data[31:0] = 0;
};

reg config_prbs_errmask {
    regwidth = 32;
    field { sw = rw; hw = r; } config_data[31:0] = 0;
};

reg stat_32_bits {
    regwidth = 32;
    field { sw = r; hw = w; } status_data[31:0] = 0;
};

reg stat_32_errs {
    regwidth = 32;
    field { sw = r; hw = w; } status_data[31:0] = 0;
};

reg stat_32_lpf_acc {
    regwidth = 32;
    field { sw = r; hw = w; } status_data[31:0] = 0;
};

reg msk_stat_3 {
    regwidth = 32;
    field { sw = r; hw = w; } xfer_count[31:0] = 0;
};

reg tx_sync_ctrl {
    regwidth = 32;
    field { sw = rw; hw = r; } tx_sync_ena = 0;
    field { sw = rw; hw = r; } tx_sync_force = 0;
    field { sw = rw; hw = r; } tx_sync_f1 = 0;
    field { sw = rw; hw = r; } tx_sync_f2 = 0;
};

reg tx_sync_cnt {
    regwidth = 32;
    field { sw = rw; hw = r; } tx_sync_cnt[23:0] = 0;
};

reg lowpass_ema_alpha {
    regwidth = 32;
    field { sw = rw; hw = r; } alpha[17:0] = 0;
};

reg rx_power {
    regwidth = 32;
    field { sw = r; hw = w; } rx_power[22:0] = 0;
};

field data32 {
    fieldwidth = 32;
    sw = r;
    hw = w;
};

reg observation_data {
    regwidth = 32;
    data32 data[31:0] = 0;
};

addrmap msk_top_regs {
    lsb0;
    default accesswidth=32;
    addressing=compact;

    desyrdl_interface = "AXI4L";
    desyrdl_access_channel = 0;

    msk_hash_lo Hash_ID_Low;
    msk_hash_hi Hash_ID_High;
    msk_init MSK_Init;
    msk_ctrl MSK_Control;
    msk_stat_0 MSK_Status;
    msk_stat_1 Tx_Bit_Count;
    msk_stat_2 Tx_Enable_Count;
    config_nco_fw Fb_FreqWord;
    config_nco_fw TX_F1_FreqWord;
    config_nco_fw TX_F2_FreqWord;
    config_nco_fw RX_F1_FreqWord;
    config_nco_fw RX_F2_FreqWord;
    lpf_config_0 LPF_Config_0;
    lpf_config_1 LPF_Config_1;
    data_width Tx_Data_Width;
    data_width Rx_Data_Width;
    prbs_ctrl PRBS_Control;
    config_prbs_seed PRBS_Initial_State;
    config_prbs_poly PRBS_Polynomial;
    config_prbs_errmask PRBS_Error_Mask;
    stat_32_bits PRBS_Bit_Count;
    stat_32_errs PRBS_Error_Count;
    stat_32_lpf_acc LPF_Accum_F1;
    stat_32_lpf_acc LPF_Accum_F2;
    msk_stat_3 axis_xfer_count;
    rx_sample_discard Rx_Sample_Discard;
    lpf_config_2 LPF_Config_2;
    observation_data f1_nco_adjust;
    observation_data f2_nco_adjust;
    observation_data f1_error;
    observation_data f2_error;
    tx_sync_ctrl Tx_Sync_Ctrl;
    tx_sync_cnt Tx_Sync_Cnt;
    lowpass_ema_alpha lowpass_ema_alpha1;
    lowpass_ema_alpha lowpass_ema_alpha2;
    rx_power rx_power;

};

